** sch_path: /home/ivan_torres/UNICASS/IHP__ADC8711/ADC8711-main/layout/klayout/ANT_DMY_array.sch
.subckt ANT_DMY_array VDD VSS
*.PININFO VDD:B VSS:B
x19[899] VDD VSS fillers
x19[898] VDD VSS fillers
x19[897] VDD VSS fillers
x19[896] VDD VSS fillers
x19[895] VDD VSS fillers
x19[894] VDD VSS fillers
x19[893] VDD VSS fillers
x19[892] VDD VSS fillers
x19[891] VDD VSS fillers
x19[890] VDD VSS fillers
x19[889] VDD VSS fillers
x19[888] VDD VSS fillers
x19[887] VDD VSS fillers
x19[886] VDD VSS fillers
x19[885] VDD VSS fillers
x19[884] VDD VSS fillers
x19[883] VDD VSS fillers
x19[882] VDD VSS fillers
x19[881] VDD VSS fillers
x19[880] VDD VSS fillers
x19[879] VDD VSS fillers
x19[878] VDD VSS fillers
x19[877] VDD VSS fillers
x19[876] VDD VSS fillers
x19[875] VDD VSS fillers
x19[874] VDD VSS fillers
x19[873] VDD VSS fillers
x19[872] VDD VSS fillers
x19[871] VDD VSS fillers
x19[870] VDD VSS fillers
x19[869] VDD VSS fillers
x19[868] VDD VSS fillers
x19[867] VDD VSS fillers
x19[866] VDD VSS fillers
x19[865] VDD VSS fillers
x19[864] VDD VSS fillers
x19[863] VDD VSS fillers
x19[862] VDD VSS fillers
x19[861] VDD VSS fillers
x19[860] VDD VSS fillers
x19[859] VDD VSS fillers
x19[858] VDD VSS fillers
x19[857] VDD VSS fillers
x19[856] VDD VSS fillers
x19[855] VDD VSS fillers
x19[854] VDD VSS fillers
x19[853] VDD VSS fillers
x19[852] VDD VSS fillers
x19[851] VDD VSS fillers
x19[850] VDD VSS fillers
x19[849] VDD VSS fillers
x19[848] VDD VSS fillers
x19[847] VDD VSS fillers
x19[846] VDD VSS fillers
x19[845] VDD VSS fillers
x19[844] VDD VSS fillers
x19[843] VDD VSS fillers
x19[842] VDD VSS fillers
x19[841] VDD VSS fillers
x19[840] VDD VSS fillers
x19[839] VDD VSS fillers
x19[838] VDD VSS fillers
x19[837] VDD VSS fillers
x19[836] VDD VSS fillers
x19[835] VDD VSS fillers
x19[834] VDD VSS fillers
x19[833] VDD VSS fillers
x19[832] VDD VSS fillers
x19[831] VDD VSS fillers
x19[830] VDD VSS fillers
x19[829] VDD VSS fillers
x19[828] VDD VSS fillers
x19[827] VDD VSS fillers
x19[826] VDD VSS fillers
x19[825] VDD VSS fillers
x19[824] VDD VSS fillers
x19[823] VDD VSS fillers
x19[822] VDD VSS fillers
x19[821] VDD VSS fillers
x19[820] VDD VSS fillers
x19[819] VDD VSS fillers
x19[818] VDD VSS fillers
x19[817] VDD VSS fillers
x19[816] VDD VSS fillers
x19[815] VDD VSS fillers
x19[814] VDD VSS fillers
x19[813] VDD VSS fillers
x19[812] VDD VSS fillers
x19[811] VDD VSS fillers
x19[810] VDD VSS fillers
x19[809] VDD VSS fillers
x19[808] VDD VSS fillers
x19[807] VDD VSS fillers
x19[806] VDD VSS fillers
x19[805] VDD VSS fillers
x19[804] VDD VSS fillers
x19[803] VDD VSS fillers
x19[802] VDD VSS fillers
x19[801] VDD VSS fillers
x19[800] VDD VSS fillers
x19[799] VDD VSS fillers
x19[798] VDD VSS fillers
x19[797] VDD VSS fillers
x19[796] VDD VSS fillers
x19[795] VDD VSS fillers
x19[794] VDD VSS fillers
x19[793] VDD VSS fillers
x19[792] VDD VSS fillers
x19[791] VDD VSS fillers
x19[790] VDD VSS fillers
x19[789] VDD VSS fillers
x19[788] VDD VSS fillers
x19[787] VDD VSS fillers
x19[786] VDD VSS fillers
x19[785] VDD VSS fillers
x19[784] VDD VSS fillers
x19[783] VDD VSS fillers
x19[782] VDD VSS fillers
x19[781] VDD VSS fillers
x19[780] VDD VSS fillers
x19[779] VDD VSS fillers
x19[778] VDD VSS fillers
x19[777] VDD VSS fillers
x19[776] VDD VSS fillers
x19[775] VDD VSS fillers
x19[774] VDD VSS fillers
x19[773] VDD VSS fillers
x19[772] VDD VSS fillers
x19[771] VDD VSS fillers
x19[770] VDD VSS fillers
x19[769] VDD VSS fillers
x19[768] VDD VSS fillers
x19[767] VDD VSS fillers
x19[766] VDD VSS fillers
x19[765] VDD VSS fillers
x19[764] VDD VSS fillers
x19[763] VDD VSS fillers
x19[762] VDD VSS fillers
x19[761] VDD VSS fillers
x19[760] VDD VSS fillers
x19[759] VDD VSS fillers
x19[758] VDD VSS fillers
x19[757] VDD VSS fillers
x19[756] VDD VSS fillers
x19[755] VDD VSS fillers
x19[754] VDD VSS fillers
x19[753] VDD VSS fillers
x19[752] VDD VSS fillers
x19[751] VDD VSS fillers
x19[750] VDD VSS fillers
x19[749] VDD VSS fillers
x19[748] VDD VSS fillers
x19[747] VDD VSS fillers
x19[746] VDD VSS fillers
x19[745] VDD VSS fillers
x19[744] VDD VSS fillers
x19[743] VDD VSS fillers
x19[742] VDD VSS fillers
x19[741] VDD VSS fillers
x19[740] VDD VSS fillers
x19[739] VDD VSS fillers
x19[738] VDD VSS fillers
x19[737] VDD VSS fillers
x19[736] VDD VSS fillers
x19[735] VDD VSS fillers
x19[734] VDD VSS fillers
x19[733] VDD VSS fillers
x19[732] VDD VSS fillers
x19[731] VDD VSS fillers
x19[730] VDD VSS fillers
x19[729] VDD VSS fillers
x19[728] VDD VSS fillers
x19[727] VDD VSS fillers
x19[726] VDD VSS fillers
x19[725] VDD VSS fillers
x19[724] VDD VSS fillers
x19[723] VDD VSS fillers
x19[722] VDD VSS fillers
x19[721] VDD VSS fillers
x19[720] VDD VSS fillers
x19[719] VDD VSS fillers
x19[718] VDD VSS fillers
x19[717] VDD VSS fillers
x19[716] VDD VSS fillers
x19[715] VDD VSS fillers
x19[714] VDD VSS fillers
x19[713] VDD VSS fillers
x19[712] VDD VSS fillers
x19[711] VDD VSS fillers
x19[710] VDD VSS fillers
x19[709] VDD VSS fillers
x19[708] VDD VSS fillers
x19[707] VDD VSS fillers
x19[706] VDD VSS fillers
x19[705] VDD VSS fillers
x19[704] VDD VSS fillers
x19[703] VDD VSS fillers
x19[702] VDD VSS fillers
x19[701] VDD VSS fillers
x19[700] VDD VSS fillers
x19[699] VDD VSS fillers
x19[698] VDD VSS fillers
x19[697] VDD VSS fillers
x19[696] VDD VSS fillers
x19[695] VDD VSS fillers
x19[694] VDD VSS fillers
x19[693] VDD VSS fillers
x19[692] VDD VSS fillers
x19[691] VDD VSS fillers
x19[690] VDD VSS fillers
x19[689] VDD VSS fillers
x19[688] VDD VSS fillers
x19[687] VDD VSS fillers
x19[686] VDD VSS fillers
x19[685] VDD VSS fillers
x19[684] VDD VSS fillers
x19[683] VDD VSS fillers
x19[682] VDD VSS fillers
x19[681] VDD VSS fillers
x19[680] VDD VSS fillers
x19[679] VDD VSS fillers
x19[678] VDD VSS fillers
x19[677] VDD VSS fillers
x19[676] VDD VSS fillers
x19[675] VDD VSS fillers
x19[674] VDD VSS fillers
x19[673] VDD VSS fillers
x19[672] VDD VSS fillers
x19[671] VDD VSS fillers
x19[670] VDD VSS fillers
x19[669] VDD VSS fillers
x19[668] VDD VSS fillers
x19[667] VDD VSS fillers
x19[666] VDD VSS fillers
x19[665] VDD VSS fillers
x19[664] VDD VSS fillers
x19[663] VDD VSS fillers
x19[662] VDD VSS fillers
x19[661] VDD VSS fillers
x19[660] VDD VSS fillers
x19[659] VDD VSS fillers
x19[658] VDD VSS fillers
x19[657] VDD VSS fillers
x19[656] VDD VSS fillers
x19[655] VDD VSS fillers
x19[654] VDD VSS fillers
x19[653] VDD VSS fillers
x19[652] VDD VSS fillers
x19[651] VDD VSS fillers
x19[650] VDD VSS fillers
x19[649] VDD VSS fillers
x19[648] VDD VSS fillers
x19[647] VDD VSS fillers
x19[646] VDD VSS fillers
x19[645] VDD VSS fillers
x19[644] VDD VSS fillers
x19[643] VDD VSS fillers
x19[642] VDD VSS fillers
x19[641] VDD VSS fillers
x19[640] VDD VSS fillers
x19[639] VDD VSS fillers
x19[638] VDD VSS fillers
x19[637] VDD VSS fillers
x19[636] VDD VSS fillers
x19[635] VDD VSS fillers
x19[634] VDD VSS fillers
x19[633] VDD VSS fillers
x19[632] VDD VSS fillers
x19[631] VDD VSS fillers
x19[630] VDD VSS fillers
x19[629] VDD VSS fillers
x19[628] VDD VSS fillers
x19[627] VDD VSS fillers
x19[626] VDD VSS fillers
x19[625] VDD VSS fillers
x19[624] VDD VSS fillers
x19[623] VDD VSS fillers
x19[622] VDD VSS fillers
x19[621] VDD VSS fillers
x19[620] VDD VSS fillers
x19[619] VDD VSS fillers
x19[618] VDD VSS fillers
x19[617] VDD VSS fillers
x19[616] VDD VSS fillers
x19[615] VDD VSS fillers
x19[614] VDD VSS fillers
x19[613] VDD VSS fillers
x19[612] VDD VSS fillers
x19[611] VDD VSS fillers
x19[610] VDD VSS fillers
x19[609] VDD VSS fillers
x19[608] VDD VSS fillers
x19[607] VDD VSS fillers
x19[606] VDD VSS fillers
x19[605] VDD VSS fillers
x19[604] VDD VSS fillers
x19[603] VDD VSS fillers
x19[602] VDD VSS fillers
x19[601] VDD VSS fillers
x19[600] VDD VSS fillers
x19[599] VDD VSS fillers
x19[598] VDD VSS fillers
x19[597] VDD VSS fillers
x19[596] VDD VSS fillers
x19[595] VDD VSS fillers
x19[594] VDD VSS fillers
x19[593] VDD VSS fillers
x19[592] VDD VSS fillers
x19[591] VDD VSS fillers
x19[590] VDD VSS fillers
x19[589] VDD VSS fillers
x19[588] VDD VSS fillers
x19[587] VDD VSS fillers
x19[586] VDD VSS fillers
x19[585] VDD VSS fillers
x19[584] VDD VSS fillers
x19[583] VDD VSS fillers
x19[582] VDD VSS fillers
x19[581] VDD VSS fillers
x19[580] VDD VSS fillers
x19[579] VDD VSS fillers
x19[578] VDD VSS fillers
x19[577] VDD VSS fillers
x19[576] VDD VSS fillers
x19[575] VDD VSS fillers
x19[574] VDD VSS fillers
x19[573] VDD VSS fillers
x19[572] VDD VSS fillers
x19[571] VDD VSS fillers
x19[570] VDD VSS fillers
x19[569] VDD VSS fillers
x19[568] VDD VSS fillers
x19[567] VDD VSS fillers
x19[566] VDD VSS fillers
x19[565] VDD VSS fillers
x19[564] VDD VSS fillers
x19[563] VDD VSS fillers
x19[562] VDD VSS fillers
x19[561] VDD VSS fillers
x19[560] VDD VSS fillers
x19[559] VDD VSS fillers
x19[558] VDD VSS fillers
x19[557] VDD VSS fillers
x19[556] VDD VSS fillers
x19[555] VDD VSS fillers
x19[554] VDD VSS fillers
x19[553] VDD VSS fillers
x19[552] VDD VSS fillers
x19[551] VDD VSS fillers
x19[550] VDD VSS fillers
x19[549] VDD VSS fillers
x19[548] VDD VSS fillers
x19[547] VDD VSS fillers
x19[546] VDD VSS fillers
x19[545] VDD VSS fillers
x19[544] VDD VSS fillers
x19[543] VDD VSS fillers
x19[542] VDD VSS fillers
x19[541] VDD VSS fillers
x19[540] VDD VSS fillers
x19[539] VDD VSS fillers
x19[538] VDD VSS fillers
x19[537] VDD VSS fillers
x19[536] VDD VSS fillers
x19[535] VDD VSS fillers
x19[534] VDD VSS fillers
x19[533] VDD VSS fillers
x19[532] VDD VSS fillers
x19[531] VDD VSS fillers
x19[530] VDD VSS fillers
x19[529] VDD VSS fillers
x19[528] VDD VSS fillers
x19[527] VDD VSS fillers
x19[526] VDD VSS fillers
x19[525] VDD VSS fillers
x19[524] VDD VSS fillers
x19[523] VDD VSS fillers
x19[522] VDD VSS fillers
x19[521] VDD VSS fillers
x19[520] VDD VSS fillers
x19[519] VDD VSS fillers
x19[518] VDD VSS fillers
x19[517] VDD VSS fillers
x19[516] VDD VSS fillers
x19[515] VDD VSS fillers
x19[514] VDD VSS fillers
x19[513] VDD VSS fillers
x19[512] VDD VSS fillers
x19[511] VDD VSS fillers
x19[510] VDD VSS fillers
x19[509] VDD VSS fillers
x19[508] VDD VSS fillers
x19[507] VDD VSS fillers
x19[506] VDD VSS fillers
x19[505] VDD VSS fillers
x19[504] VDD VSS fillers
x19[503] VDD VSS fillers
x19[502] VDD VSS fillers
x19[501] VDD VSS fillers
x19[500] VDD VSS fillers
x19[499] VDD VSS fillers
x19[498] VDD VSS fillers
x19[497] VDD VSS fillers
x19[496] VDD VSS fillers
x19[495] VDD VSS fillers
x19[494] VDD VSS fillers
x19[493] VDD VSS fillers
x19[492] VDD VSS fillers
x19[491] VDD VSS fillers
x19[490] VDD VSS fillers
x19[489] VDD VSS fillers
x19[488] VDD VSS fillers
x19[487] VDD VSS fillers
x19[486] VDD VSS fillers
x19[485] VDD VSS fillers
x19[484] VDD VSS fillers
x19[483] VDD VSS fillers
x19[482] VDD VSS fillers
x19[481] VDD VSS fillers
x19[480] VDD VSS fillers
x19[479] VDD VSS fillers
x19[478] VDD VSS fillers
x19[477] VDD VSS fillers
x19[476] VDD VSS fillers
x19[475] VDD VSS fillers
x19[474] VDD VSS fillers
x19[473] VDD VSS fillers
x19[472] VDD VSS fillers
x19[471] VDD VSS fillers
x19[470] VDD VSS fillers
x19[469] VDD VSS fillers
x19[468] VDD VSS fillers
x19[467] VDD VSS fillers
x19[466] VDD VSS fillers
x19[465] VDD VSS fillers
x19[464] VDD VSS fillers
x19[463] VDD VSS fillers
x19[462] VDD VSS fillers
x19[461] VDD VSS fillers
x19[460] VDD VSS fillers
x19[459] VDD VSS fillers
x19[458] VDD VSS fillers
x19[457] VDD VSS fillers
x19[456] VDD VSS fillers
x19[455] VDD VSS fillers
x19[454] VDD VSS fillers
x19[453] VDD VSS fillers
x19[452] VDD VSS fillers
x19[451] VDD VSS fillers
x19[450] VDD VSS fillers
x19[449] VDD VSS fillers
x19[448] VDD VSS fillers
x19[447] VDD VSS fillers
x19[446] VDD VSS fillers
x19[445] VDD VSS fillers
x19[444] VDD VSS fillers
x19[443] VDD VSS fillers
x19[442] VDD VSS fillers
x19[441] VDD VSS fillers
x19[440] VDD VSS fillers
x19[439] VDD VSS fillers
x19[438] VDD VSS fillers
x19[437] VDD VSS fillers
x19[436] VDD VSS fillers
x19[435] VDD VSS fillers
x19[434] VDD VSS fillers
x19[433] VDD VSS fillers
x19[432] VDD VSS fillers
x19[431] VDD VSS fillers
x19[430] VDD VSS fillers
x19[429] VDD VSS fillers
x19[428] VDD VSS fillers
x19[427] VDD VSS fillers
x19[426] VDD VSS fillers
x19[425] VDD VSS fillers
x19[424] VDD VSS fillers
x19[423] VDD VSS fillers
x19[422] VDD VSS fillers
x19[421] VDD VSS fillers
x19[420] VDD VSS fillers
x19[419] VDD VSS fillers
x19[418] VDD VSS fillers
x19[417] VDD VSS fillers
x19[416] VDD VSS fillers
x19[415] VDD VSS fillers
x19[414] VDD VSS fillers
x19[413] VDD VSS fillers
x19[412] VDD VSS fillers
x19[411] VDD VSS fillers
x19[410] VDD VSS fillers
x19[409] VDD VSS fillers
x19[408] VDD VSS fillers
x19[407] VDD VSS fillers
x19[406] VDD VSS fillers
x19[405] VDD VSS fillers
x19[404] VDD VSS fillers
x19[403] VDD VSS fillers
x19[402] VDD VSS fillers
x19[401] VDD VSS fillers
x19[400] VDD VSS fillers
x19[399] VDD VSS fillers
x19[398] VDD VSS fillers
x19[397] VDD VSS fillers
x19[396] VDD VSS fillers
x19[395] VDD VSS fillers
x19[394] VDD VSS fillers
x19[393] VDD VSS fillers
x19[392] VDD VSS fillers
x19[391] VDD VSS fillers
x19[390] VDD VSS fillers
x19[389] VDD VSS fillers
x19[388] VDD VSS fillers
x19[387] VDD VSS fillers
x19[386] VDD VSS fillers
x19[385] VDD VSS fillers
x19[384] VDD VSS fillers
x19[383] VDD VSS fillers
x19[382] VDD VSS fillers
x19[381] VDD VSS fillers
x19[380] VDD VSS fillers
x19[379] VDD VSS fillers
x19[378] VDD VSS fillers
x19[377] VDD VSS fillers
x19[376] VDD VSS fillers
x19[375] VDD VSS fillers
x19[374] VDD VSS fillers
x19[373] VDD VSS fillers
x19[372] VDD VSS fillers
x19[371] VDD VSS fillers
x19[370] VDD VSS fillers
x19[369] VDD VSS fillers
x19[368] VDD VSS fillers
x19[367] VDD VSS fillers
x19[366] VDD VSS fillers
x19[365] VDD VSS fillers
x19[364] VDD VSS fillers
x19[363] VDD VSS fillers
x19[362] VDD VSS fillers
x19[361] VDD VSS fillers
x19[360] VDD VSS fillers
x19[359] VDD VSS fillers
x19[358] VDD VSS fillers
x19[357] VDD VSS fillers
x19[356] VDD VSS fillers
x19[355] VDD VSS fillers
x19[354] VDD VSS fillers
x19[353] VDD VSS fillers
x19[352] VDD VSS fillers
x19[351] VDD VSS fillers
x19[350] VDD VSS fillers
x19[349] VDD VSS fillers
x19[348] VDD VSS fillers
x19[347] VDD VSS fillers
x19[346] VDD VSS fillers
x19[345] VDD VSS fillers
x19[344] VDD VSS fillers
x19[343] VDD VSS fillers
x19[342] VDD VSS fillers
x19[341] VDD VSS fillers
x19[340] VDD VSS fillers
x19[339] VDD VSS fillers
x19[338] VDD VSS fillers
x19[337] VDD VSS fillers
x19[336] VDD VSS fillers
x19[335] VDD VSS fillers
x19[334] VDD VSS fillers
x19[333] VDD VSS fillers
x19[332] VDD VSS fillers
x19[331] VDD VSS fillers
x19[330] VDD VSS fillers
x19[329] VDD VSS fillers
x19[328] VDD VSS fillers
x19[327] VDD VSS fillers
x19[326] VDD VSS fillers
x19[325] VDD VSS fillers
x19[324] VDD VSS fillers
x19[323] VDD VSS fillers
x19[322] VDD VSS fillers
x19[321] VDD VSS fillers
x19[320] VDD VSS fillers
x19[319] VDD VSS fillers
x19[318] VDD VSS fillers
x19[317] VDD VSS fillers
x19[316] VDD VSS fillers
x19[315] VDD VSS fillers
x19[314] VDD VSS fillers
x19[313] VDD VSS fillers
x19[312] VDD VSS fillers
x19[311] VDD VSS fillers
x19[310] VDD VSS fillers
x19[309] VDD VSS fillers
x19[308] VDD VSS fillers
x19[307] VDD VSS fillers
x19[306] VDD VSS fillers
x19[305] VDD VSS fillers
x19[304] VDD VSS fillers
x19[303] VDD VSS fillers
x19[302] VDD VSS fillers
x19[301] VDD VSS fillers
x19[300] VDD VSS fillers
x19[299] VDD VSS fillers
x19[298] VDD VSS fillers
x19[297] VDD VSS fillers
x19[296] VDD VSS fillers
x19[295] VDD VSS fillers
x19[294] VDD VSS fillers
x19[293] VDD VSS fillers
x19[292] VDD VSS fillers
x19[291] VDD VSS fillers
x19[290] VDD VSS fillers
x19[289] VDD VSS fillers
x19[288] VDD VSS fillers
x19[287] VDD VSS fillers
x19[286] VDD VSS fillers
x19[285] VDD VSS fillers
x19[284] VDD VSS fillers
x19[283] VDD VSS fillers
x19[282] VDD VSS fillers
x19[281] VDD VSS fillers
x19[280] VDD VSS fillers
x19[279] VDD VSS fillers
x19[278] VDD VSS fillers
x19[277] VDD VSS fillers
x19[276] VDD VSS fillers
x19[275] VDD VSS fillers
x19[274] VDD VSS fillers
x19[273] VDD VSS fillers
x19[272] VDD VSS fillers
x19[271] VDD VSS fillers
x19[270] VDD VSS fillers
x19[269] VDD VSS fillers
x19[268] VDD VSS fillers
x19[267] VDD VSS fillers
x19[266] VDD VSS fillers
x19[265] VDD VSS fillers
x19[264] VDD VSS fillers
x19[263] VDD VSS fillers
x19[262] VDD VSS fillers
x19[261] VDD VSS fillers
x19[260] VDD VSS fillers
x19[259] VDD VSS fillers
x19[258] VDD VSS fillers
x19[257] VDD VSS fillers
x19[256] VDD VSS fillers
x19[255] VDD VSS fillers
x19[254] VDD VSS fillers
x19[253] VDD VSS fillers
x19[252] VDD VSS fillers
x19[251] VDD VSS fillers
x19[250] VDD VSS fillers
x19[249] VDD VSS fillers
x19[248] VDD VSS fillers
x19[247] VDD VSS fillers
x19[246] VDD VSS fillers
x19[245] VDD VSS fillers
x19[244] VDD VSS fillers
x19[243] VDD VSS fillers
x19[242] VDD VSS fillers
x19[241] VDD VSS fillers
x19[240] VDD VSS fillers
x19[239] VDD VSS fillers
x19[238] VDD VSS fillers
x19[237] VDD VSS fillers
x19[236] VDD VSS fillers
x19[235] VDD VSS fillers
x19[234] VDD VSS fillers
x19[233] VDD VSS fillers
x19[232] VDD VSS fillers
x19[231] VDD VSS fillers
x19[230] VDD VSS fillers
x19[229] VDD VSS fillers
x19[228] VDD VSS fillers
x19[227] VDD VSS fillers
x19[226] VDD VSS fillers
x19[225] VDD VSS fillers
x19[224] VDD VSS fillers
x19[223] VDD VSS fillers
x19[222] VDD VSS fillers
x19[221] VDD VSS fillers
x19[220] VDD VSS fillers
x19[219] VDD VSS fillers
x19[218] VDD VSS fillers
x19[217] VDD VSS fillers
x19[216] VDD VSS fillers
x19[215] VDD VSS fillers
x19[214] VDD VSS fillers
x19[213] VDD VSS fillers
x19[212] VDD VSS fillers
x19[211] VDD VSS fillers
x19[210] VDD VSS fillers
x19[209] VDD VSS fillers
x19[208] VDD VSS fillers
x19[207] VDD VSS fillers
x19[206] VDD VSS fillers
x19[205] VDD VSS fillers
x19[204] VDD VSS fillers
x19[203] VDD VSS fillers
x19[202] VDD VSS fillers
x19[201] VDD VSS fillers
x19[200] VDD VSS fillers
x19[199] VDD VSS fillers
x19[198] VDD VSS fillers
x19[197] VDD VSS fillers
x19[196] VDD VSS fillers
x19[195] VDD VSS fillers
x19[194] VDD VSS fillers
x19[193] VDD VSS fillers
x19[192] VDD VSS fillers
x19[191] VDD VSS fillers
x19[190] VDD VSS fillers
x19[189] VDD VSS fillers
x19[188] VDD VSS fillers
x19[187] VDD VSS fillers
x19[186] VDD VSS fillers
x19[185] VDD VSS fillers
x19[184] VDD VSS fillers
x19[183] VDD VSS fillers
x19[182] VDD VSS fillers
x19[181] VDD VSS fillers
x19[180] VDD VSS fillers
x19[179] VDD VSS fillers
x19[178] VDD VSS fillers
x19[177] VDD VSS fillers
x19[176] VDD VSS fillers
x19[175] VDD VSS fillers
x19[174] VDD VSS fillers
x19[173] VDD VSS fillers
x19[172] VDD VSS fillers
x19[171] VDD VSS fillers
x19[170] VDD VSS fillers
x19[169] VDD VSS fillers
x19[168] VDD VSS fillers
x19[167] VDD VSS fillers
x19[166] VDD VSS fillers
x19[165] VDD VSS fillers
x19[164] VDD VSS fillers
x19[163] VDD VSS fillers
x19[162] VDD VSS fillers
x19[161] VDD VSS fillers
x19[160] VDD VSS fillers
x19[159] VDD VSS fillers
x19[158] VDD VSS fillers
x19[157] VDD VSS fillers
x19[156] VDD VSS fillers
x19[155] VDD VSS fillers
x19[154] VDD VSS fillers
x19[153] VDD VSS fillers
x19[152] VDD VSS fillers
x19[151] VDD VSS fillers
x19[150] VDD VSS fillers
x19[149] VDD VSS fillers
x19[148] VDD VSS fillers
x19[147] VDD VSS fillers
x19[146] VDD VSS fillers
x19[145] VDD VSS fillers
x19[144] VDD VSS fillers
x19[143] VDD VSS fillers
x19[142] VDD VSS fillers
x19[141] VDD VSS fillers
x19[140] VDD VSS fillers
x19[139] VDD VSS fillers
x19[138] VDD VSS fillers
x19[137] VDD VSS fillers
x19[136] VDD VSS fillers
x19[135] VDD VSS fillers
x19[134] VDD VSS fillers
x19[133] VDD VSS fillers
x19[132] VDD VSS fillers
x19[131] VDD VSS fillers
x19[130] VDD VSS fillers
x19[129] VDD VSS fillers
x19[128] VDD VSS fillers
x19[127] VDD VSS fillers
x19[126] VDD VSS fillers
x19[125] VDD VSS fillers
x19[124] VDD VSS fillers
x19[123] VDD VSS fillers
x19[122] VDD VSS fillers
x19[121] VDD VSS fillers
x19[120] VDD VSS fillers
x19[119] VDD VSS fillers
x19[118] VDD VSS fillers
x19[117] VDD VSS fillers
x19[116] VDD VSS fillers
x19[115] VDD VSS fillers
x19[114] VDD VSS fillers
x19[113] VDD VSS fillers
x19[112] VDD VSS fillers
x19[111] VDD VSS fillers
x19[110] VDD VSS fillers
x19[109] VDD VSS fillers
x19[108] VDD VSS fillers
x19[107] VDD VSS fillers
x19[106] VDD VSS fillers
x19[105] VDD VSS fillers
x19[104] VDD VSS fillers
x19[103] VDD VSS fillers
x19[102] VDD VSS fillers
x19[101] VDD VSS fillers
x19[100] VDD VSS fillers
x19[99] VDD VSS fillers
x19[98] VDD VSS fillers
x19[97] VDD VSS fillers
x19[96] VDD VSS fillers
x19[95] VDD VSS fillers
x19[94] VDD VSS fillers
x19[93] VDD VSS fillers
x19[92] VDD VSS fillers
x19[91] VDD VSS fillers
x19[90] VDD VSS fillers
x19[89] VDD VSS fillers
x19[88] VDD VSS fillers
x19[87] VDD VSS fillers
x19[86] VDD VSS fillers
x19[85] VDD VSS fillers
x19[84] VDD VSS fillers
x19[83] VDD VSS fillers
x19[82] VDD VSS fillers
x19[81] VDD VSS fillers
x19[80] VDD VSS fillers
x19[79] VDD VSS fillers
x19[78] VDD VSS fillers
x19[77] VDD VSS fillers
x19[76] VDD VSS fillers
x19[75] VDD VSS fillers
x19[74] VDD VSS fillers
x19[73] VDD VSS fillers
x19[72] VDD VSS fillers
x19[71] VDD VSS fillers
x19[70] VDD VSS fillers
x19[69] VDD VSS fillers
x19[68] VDD VSS fillers
x19[67] VDD VSS fillers
x19[66] VDD VSS fillers
x19[65] VDD VSS fillers
x19[64] VDD VSS fillers
x19[63] VDD VSS fillers
x19[62] VDD VSS fillers
x19[61] VDD VSS fillers
x19[60] VDD VSS fillers
x19[59] VDD VSS fillers
x19[58] VDD VSS fillers
x19[57] VDD VSS fillers
x19[56] VDD VSS fillers
x19[55] VDD VSS fillers
x19[54] VDD VSS fillers
x19[53] VDD VSS fillers
x19[52] VDD VSS fillers
x19[51] VDD VSS fillers
x19[50] VDD VSS fillers
x19[49] VDD VSS fillers
x19[48] VDD VSS fillers
x19[47] VDD VSS fillers
x19[46] VDD VSS fillers
x19[45] VDD VSS fillers
x19[44] VDD VSS fillers
x19[43] VDD VSS fillers
x19[42] VDD VSS fillers
x19[41] VDD VSS fillers
x19[40] VDD VSS fillers
x19[39] VDD VSS fillers
x19[38] VDD VSS fillers
x19[37] VDD VSS fillers
x19[36] VDD VSS fillers
x19[35] VDD VSS fillers
x19[34] VDD VSS fillers
x19[33] VDD VSS fillers
x19[32] VDD VSS fillers
x19[31] VDD VSS fillers
x19[30] VDD VSS fillers
x19[29] VDD VSS fillers
x19[28] VDD VSS fillers
x19[27] VDD VSS fillers
x19[26] VDD VSS fillers
x19[25] VDD VSS fillers
x19[24] VDD VSS fillers
x19[23] VDD VSS fillers
x19[22] VDD VSS fillers
x19[21] VDD VSS fillers
x19[20] VDD VSS fillers
x19[19] VDD VSS fillers
x19[18] VDD VSS fillers
x19[17] VDD VSS fillers
x19[16] VDD VSS fillers
x19[15] VDD VSS fillers
x19[14] VDD VSS fillers
x19[13] VDD VSS fillers
x19[12] VDD VSS fillers
x19[11] VDD VSS fillers
x19[10] VDD VSS fillers
x19[9] VDD VSS fillers
x19[8] VDD VSS fillers
x19[7] VDD VSS fillers
x19[6] VDD VSS fillers
x19[5] VDD VSS fillers
x19[4] VDD VSS fillers
x19[3] VDD VSS fillers
x19[2] VDD VSS fillers
x19[1] VDD VSS fillers
x19[0] VDD VSS fillers
.ends

* expanding   symbol:  fillers.sym # of pins=2
** sym_path: /home/ivan_torres/UNICASS/IHP__ADC8711/ADC8711-main/schematic/xschem/fillers.sym
** sch_path: /home/ivan_torres/UNICASS/IHP__ADC8711/ADC8711-main/schematic/xschem/fillers.sch
.subckt fillers VDD VSS
*.PININFO VDD:B VSS:B
MM2 VDD VDD VDD VDD sg13_lv_pmos w=0.15u l=0.13u ng=1
MM1 VSS VSS VSS VSS sg13_lv_nmos w=0.15u l=0.13u ng=1
.ends
