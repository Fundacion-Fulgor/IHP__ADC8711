** sch_path: $SCRIPT_DIR/ADC8711-main/schematic/xschem/MUX_8_1_NI.sch
.subckt MUX_8_1_NI VINA VINB VDD VOUT CTRL[2] CTRL[1] CTRL[0] VINC VSS VIND VINE VINF VING VINH
*.PININFO VSS:B VOUT:O VDD:B VINA:I VINB:I VINC:I VIND:I CTRL[2:0]:I VINE:I VINF:I VING:I VINH:I
x7 VDD net1 VOUT CTRL[2] net2 VSS MUX_2_1_NI
x8 VINA VINB VDD net1 CTRL[1] CTRL[0] VINC VSS VIND MUX_4_1_NI
x9 VINE VINF VDD net2 CTRL[1] CTRL[0] VING VSS VINH MUX_4_1_NI
.ends

* expanding   symbol:  MUX_2_1_NI.sym # of pins=6
** sym_path: $SCRIPT_DIR/ADC8711-main/schematic/xschem/MUX_2_1_NI.sym
** sch_path: $SCRIPT_DIR/ADC8711-main/schematic/xschem/MUX_2_1_NI.sch
.subckt MUX_2_1_NI VDD VINA VOUT VS VINB VSS
*.PININFO VOUT:O VINA:I VINB:I VS:I VDD:B VSS:B
x6[1] VSB VSS VOUT VINA VDD VS TG_2C
x6[0] VSB VSS VOUT VINA VDD VS TG_2C
x2[1] VS VSS VOUT VINB VDD VSB TG_2C
x2[0] VS VSS VOUT VINB VDD VSB TG_2C
x1 VDD VSB VS VSS INV_D3
.ends

* expanding   symbol:  MUX_4_1_NI.sym # of pins=8
** sym_path: $SCRIPT_DIR/ADC8711-main/schematic/xschem/MUX_4_1_NI.sym
** sch_path: $SCRIPT_DIR/ADC8711-main/schematic/xschem/MUX_4_1_NI.sch
.subckt MUX_4_1_NI VINA VINB VDD VOUT VS[1] VS[0] VINC VSS VIND
*.PININFO VOUT:O VDD:B VSS:B VINA:I VINB:I VINC:I VIND:I VS[1:0]:I
x3 VDD VINA net1 VS[0] VINB VSS MUX_2_1_NI
x1 VDD VINC net2 VS[0] VIND VSS MUX_2_1_NI
x2 VDD net1 VOUT VS[1] net2 VSS MUX_2_1_NI
.ends

* expanding   symbol:  TG_2C.sym # of pins=6
** sym_path: $SCRIPT_DIR/ADC8711-main/schematic/xschem/TG_2C.sym
** sch_path: $SCRIPT_DIR/ADC8711-main/schematic/xschem/TG_2C.sch
.subckt TG_2C VCTRLN VSS VOUT VIN VDD VCTRLP
*.PININFO VCTRLN:B VCTRLP:B VOUT:O VIN:I VSS:B VDD:B
MM1 VOUT VCTRLN VIN VSS sg13_lv_nmos w=0.15u l=0.13u ng=1
MM2 VOUT VCTRLP VIN VDD sg13_lv_pmos w=0.15u l=0.13u ng=1 m=2
.ends

* expanding   symbol:  INV_D3.sym # of pins=4
** sym_path: $SCRIPT_DIR/ADC8711-main/schematic/xschem/INV_D3.sym
** sch_path: $SCRIPT_DIR/ADC8711-main/schematic/xschem/INV_D3.sch
.subckt INV_D3 VDD VOUT VIN VSS
*.PININFO VDD:B VSS:B VOUT:O VIN:I
MM1 VOUT VIN VSS VSS sg13_lv_nmos w=0.15u l=0.13u ng=1 m=3
MM2 VOUT VIN VDD VDD sg13_lv_pmos w=0.15u l=0.13u ng=1 m=6
.ends
