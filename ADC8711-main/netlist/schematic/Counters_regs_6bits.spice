** sch_path: /home/ivan_torres/UNICASS/GRO-TDC/design/schematic/Counters_regs_6bits.sch
.subckt Counters_regs_6bits RESET D0_B[5] D0_B[4] D0_B[3] D0_B[2] D0_B[1] D0_B[0] VDD CLK VSS D1_B[5] D1_B[4] D1_B[3] D1_B[2]
+ D1_B[1] D1_B[0] D2_B[5] D2_B[4] D2_B[3] D2_B[2] D2_B[1] D2_B[0] C0_B[5] C0_B[4] C0_B[3] C0_B[2] C0_B[1] C0_B[0] C1_B[5] C1_B[4] C1_B[3]
+ C1_B[2] C1_B[1] C1_B[0] C2_B[5] C2_B[4] C2_B[3] C2_B[2] C2_B[1] C2_B[0]
*.PININFO VDD:B VSS:B RESET:I C0_B[5:0]:I C1_B[5:0]:I C2_B[5:0]:I D0_B[5:0]:O D1_B[5:0]:O D2_B[5:0]:O CLK:I
x8 VDD CLK RESET VSS D0_B[0] net1 C0_B[0] FF_D
x1 VDD CLK RESET VSS D0_B[1] net2 C0_B[1] FF_D
x2 VDD CLK RESET VSS D0_B[2] net3 C0_B[2] FF_D
x3 VDD CLK RESET VSS D0_B[3] net4 C0_B[3] FF_D
x4 VDD CLK RESET VSS D0_B[4] net5 C0_B[4] FF_D
x5 VDD CLK RESET VSS D0_B[5] net6 C0_B[5] FF_D
x6 VDD CLK RESET VSS D1_B[0] net7 C1_B[0] FF_D
x7 VDD CLK RESET VSS D1_B[1] net8 C1_B[1] FF_D
x9 VDD CLK RESET VSS D1_B[2] net9 C1_B[2] FF_D
x10 VDD CLK RESET VSS D1_B[3] net10 C1_B[3] FF_D
x11 VDD CLK RESET VSS D1_B[4] net11 C1_B[4] FF_D
x12 VDD CLK RESET VSS D1_B[5] net12 C1_B[5] FF_D
x13 VDD CLK RESET VSS D2_B[0] net13 C2_B[0] FF_D
x14 VDD CLK RESET VSS D2_B[1] net14 C2_B[1] FF_D
x15 VDD CLK RESET VSS D2_B[2] net15 C2_B[2] FF_D
x16 VDD CLK RESET VSS D2_B[3] net16 C2_B[3] FF_D
x17 VDD CLK RESET VSS D2_B[4] net17 C2_B[4] FF_D
x18 VDD CLK RESET VSS D2_B[5] net18 C2_B[5] FF_D
.ends

* expanding   symbol:  FF_D.sym # of pins=7
** sym_path: /home/ivan_torres/UNICASS/GRO-TDC/design/schematic/FF_D.sym
** sch_path: /home/ivan_torres/UNICASS/GRO-TDC/design/schematic/FF_D.sch
.subckt FF_D VDD VCLK VRESET VSS VQ VQN VD
*.PININFO VDD:B VSS:B VCLK:I VD:I VRESET:I VQ:O VQN:O
x1 VDD net4 VD VSS INV_D1
x2 VDD net2 net1 VSS INV_D1
x3 VCLK VSS net7 net2 VDD VCLK_N TG_2C
x4 VCLK_N VSS net7 net4 VDD VCLK TG_2C
x5 VCLK VSS net6 net5 VDD VCLK_N TG_2C
x6 VDD net3 VQ VSS INV_D1
x7 VCLK_N VSS net6 net3 VDD VCLK TG_2C
x8 VDD net7 net1 VRESET_N VSS NAND_D2
x9 VDD net6 VQ VRESET_N VSS NAND_D3
x10 VDD VCLK_N VCLK VSS INV_D1
x11 VDD net5 net1 VSS INV_D3
x12 VDD VRESET_N VRESET VSS INV_D1
x13 VDD VQN VQ VSS INV_D1
.ends

* expanding   symbol:  INV_D1.sym # of pins=4
** sym_path: /home/ivan_torres/UNICASS/GRO-TDC/design/schematic/INV_D1.sym
** sch_path: /home/ivan_torres/UNICASS/GRO-TDC/design/schematic/INV_D1.sch
.subckt INV_D1 VDD VOUT VIN VSS
*.PININFO VDD:B VSS:B VOUT:O VIN:I
MM2 VOUT VIN VDD VDD sg13_lv_pmos w=0.3u l=0.13u ng=1
MM1 VOUT VIN VSS VSS sg13_lv_nmos w=0.15u l=0.13u ng=1
.ends

* expanding   symbol:  TG_2C.sym # of pins=6
** sym_path: /home/ivan_torres/UNICASS/GRO-TDC/design/schematic/TG_2C.sym
** sch_path: /home/ivan_torres/UNICASS/GRO-TDC/design/schematic/TG_2C.sch
.subckt TG_2C VCTRLN VSS VOUT VIN VDD VCTRLP
*.PININFO VCTRLN:B VCTRLP:B VOUT:O VIN:I VSS:B VDD:B
MM1 VOUT VCTRLN VIN VSS sg13_lv_nmos w=0.15u l=0.13u ng=1
MM2 VOUT VCTRLP VIN VDD sg13_lv_pmos w=0.15u l=0.13u ng=1 m=2
.ends

* expanding   symbol:  NAND_D2.sym # of pins=5
** sym_path: /home/ivan_torres/UNICASS/GRO-TDC/design/schematic/NAND_D2.sym
** sch_path: /home/ivan_torres/UNICASS/GRO-TDC/design/schematic/NAND_D2.sch
.subckt NAND_D2 VDD VA VOUT VB VSS
*.PININFO VDD:B VSS:B VA:I VB:I VOUT:O
MM1 net1 VB VSS VSS sg13_lv_nmos w=0.9u l=0.13u ng=1
MM2 VOUT VA net1 VSS sg13_lv_nmos w=0.3u l=0.13u ng=1
MM3 VOUT VB VDD VDD sg13_lv_pmos w=0.3u l=0.13u ng=1
MM4 VOUT VA VDD VDD sg13_lv_pmos w=0.3u l=0.13u ng=1
.ends

* expanding   symbol:  NAND_D3.sym # of pins=5
** sym_path: /home/ivan_torres/UNICASS/GRO-TDC/design/schematic/NAND_D3.sym
** sch_path: /home/ivan_torres/UNICASS/GRO-TDC/design/schematic/NAND_D3.sch
.subckt NAND_D3 VDD VA VOUT VB VSS
*.PININFO VDD:B VSS:B VA:I VB:I VOUT:O
MM1 net1 VB VSS VSS sg13_lv_nmos w=1.35u l=0.13u ng=1
MM2 VOUT VA net1 VSS sg13_lv_nmos w=0.45u l=0.13u ng=1
MM3 VOUT VB VDD VDD sg13_lv_pmos w=0.45u l=0.13u ng=1
MM4 VOUT VA VDD VDD sg13_lv_pmos w=0.45u l=0.13u ng=1
.ends

* expanding   symbol:  INV_D3.sym # of pins=4
** sym_path: /home/ivan_torres/UNICASS/GRO-TDC/design/schematic/INV_D3.sym
** sch_path: /home/ivan_torres/UNICASS/GRO-TDC/design/schematic/INV_D3.sch
.subckt INV_D3 VDD VOUT VIN VSS
*.PININFO VDD:B VSS:B VOUT:O VIN:I
MM1 VOUT VIN VSS VSS sg13_lv_nmos w=0.15u l=0.13u ng=1 m=3
MM2 VOUT VIN VDD VDD sg13_lv_pmos w=0.15u l=0.13u ng=1 m=6
.ends
