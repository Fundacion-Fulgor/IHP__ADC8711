** sch_path: $SCRIPT_DIR/ADC8711-main/schematic/xschem/Buffers_adder.sch
.subckt Buffers_adder VDD IN VSS OUT
*.PININFO IN:I VDD:B VSS:B OUT:O
x5[1] VDD net1 IN VSS INV_D1
x5[0] VDD net1 IN VSS INV_D1
x6[3] VDD net2 net1 VSS INV_D1
x6[2] VDD net2 net1 VSS INV_D1
x6[1] VDD net2 net1 VSS INV_D1
x6[0] VDD net2 net1 VSS INV_D1
x7[7] VDD net3 net2 VSS INV_D1
x7[6] VDD net3 net2 VSS INV_D1
x7[5] VDD net3 net2 VSS INV_D1
x7[4] VDD net3 net2 VSS INV_D1
x7[3] VDD net3 net2 VSS INV_D1
x7[2] VDD net3 net2 VSS INV_D1
x7[1] VDD net3 net2 VSS INV_D1
x7[0] VDD net3 net2 VSS INV_D1
x8[15] VDD OUT net3 VSS INV_D1
x8[14] VDD OUT net3 VSS INV_D1
x8[13] VDD OUT net3 VSS INV_D1
x8[12] VDD OUT net3 VSS INV_D1
x8[11] VDD OUT net3 VSS INV_D1
x8[10] VDD OUT net3 VSS INV_D1
x8[9] VDD OUT net3 VSS INV_D1
x8[8] VDD OUT net3 VSS INV_D1
x8[7] VDD OUT net3 VSS INV_D1
x8[6] VDD OUT net3 VSS INV_D1
x8[5] VDD OUT net3 VSS INV_D1
x8[4] VDD OUT net3 VSS INV_D1
x8[3] VDD OUT net3 VSS INV_D1
x8[2] VDD OUT net3 VSS INV_D1
x8[1] VDD OUT net3 VSS INV_D1
x8[0] VDD OUT net3 VSS INV_D1
.ends

* expanding   symbol:  INV_D1.sym # of pins=4
** sym_path: $SCRIPT_DIR/ADC8711-main/schematic/xschem/INV_D1.sym
** sch_path: $SCRIPT_DIR/ADC8711-main/schematic/xschem/INV_D1.sch
.subckt INV_D1 VDD VOUT VIN VSS
*.PININFO VDD:B VSS:B VOUT:O VIN:I
MM2 VOUT VIN VDD VDD sg13_lv_pmos w=0.3u l=0.13u ng=1
MM1 VOUT VIN VSS VSS sg13_lv_nmos w=0.15u l=0.13u ng=1
.ends
