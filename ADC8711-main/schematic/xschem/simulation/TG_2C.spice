** sch_path: $SCRIPT_DIR/ADC8711-main/schematic/xschem/TG_2C.sch
.subckt TG_2C VCTRLN VSS VOUT VIN VDD VCTRLP
*.PININFO VCTRLN:B VCTRLP:B VOUT:O VIN:I VSS:B VDD:B
MM1 VOUT VCTRLN VIN VSS sg13_lv_nmos w=0.15u l=0.13u ng=1
MM2 VOUT VCTRLP VIN VDD sg13_lv_pmos w=0.15u l=0.13u ng=1 m=2
.ends
