** sch_path: $SCRIPT_DIR/ADC8711-main/schematic/xschem/delay_prog_sub.sch
.subckt delay_prog_sub OUT IN VDD VSS CTRL[2] CTRL[1] CTRL[0]
*.PININFO IN:I OUT:O VDD:B VSS:B CTRL[2:0]:I
x1 VDD net1 IN VSS INV_D1
x2 VDD OUT net2 VSS INV_D2
x3 CTRL[0] VSS net2 net1 VDD CTRLN[0] TG_2C
x4 CTRL[1] VSS net2 net1 VDD CTRLN[1] TG_2C
x5 CTRL[2] VSS net2 net1 VDD CTRLN[2] TG_2C
x6 VDD CTRLN[0] CTRL[0] VSS INV_D1
x7 VDD CTRLN[1] CTRL[1] VSS INV_D1
x8 VDD CTRLN[2] CTRL[2] VSS INV_D1
.ends

* expanding   symbol:  INV_D1.sym # of pins=4
** sym_path: $SCRIPT_DIR/ADC8711-main/schematic/xschem/INV_D1.sym
** sch_path: $SCRIPT_DIR/ADC8711-main/schematic/xschem/INV_D1.sch
.subckt INV_D1 VDD VOUT VIN VSS
*.PININFO VDD:B VSS:B VOUT:O VIN:I
MM2 VOUT VIN VDD VDD sg13_lv_pmos w=0.3u l=0.13u ng=1
MM1 VOUT VIN VSS VSS sg13_lv_nmos w=0.15u l=0.13u ng=1
.ends

* expanding   symbol:  INV_D2.sym # of pins=4
** sym_path: $SCRIPT_DIR/ADC8711-main/schematic/xschem/INV_D2.sym
** sch_path: $SCRIPT_DIR/ADC8711-main/schematic/xschem/INV_D2.sch
.subckt INV_D2 VDD VOUT VIN VSS
*.PININFO VDD:B VSS:B VOUT:O VIN:I
MM1 VOUT VIN VSS VSS sg13_lv_nmos w=0.3u l=0.13u ng=1
MM2 VOUT VIN VDD VDD sg13_lv_pmos w=0.3u l=0.13u ng=1
.ends

* expanding   symbol:  TG_2C.sym # of pins=6
** sym_path: $SCRIPT_DIR/ADC8711-main/schematic/xschem/TG_2C.sym
** sch_path: $SCRIPT_DIR/ADC8711-main/schematic/xschem/TG_2C.sch
.subckt TG_2C VCTRLN VSS VOUT VIN VDD VCTRLP
*.PININFO VCTRLN:B VCTRLP:B VOUT:O VIN:I VSS:B VDD:B
MM1 VOUT VCTRLN VIN VSS sg13_lv_nmos w=0.15u l=0.13u ng=1
MM2 VOUT VCTRLP VIN VDD sg13_lv_pmos w=0.15u l=0.13u ng=1 m=2
.ends
