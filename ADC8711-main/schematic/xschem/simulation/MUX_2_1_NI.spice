** sch_path: /home/ivan_torres/UNICASS/IHP__ADC8711/ADC8711-main/schematic/xschem/MUX_2_1_NI.sch
.subckt MUX_2_1_NI VDD VINA VOUT VS VINB VSS
*.PININFO VOUT:O VINA:I VINB:I VS:I VDD:B VSS:B
x6[1] VSB VSS VOUT VINA VDD VS TG_2C
x6[0] VSB VSS VOUT VINA VDD VS TG_2C
x2[1] VS VSS VOUT VINB VDD VSB TG_2C
x2[0] VS VSS VOUT VINB VDD VSB TG_2C
x1 VDD VSB VS VSS INV_D3
.ends

* expanding   symbol:  TG_2C.sym # of pins=6
** sym_path: /home/ivan_torres/UNICASS/IHP__ADC8711/ADC8711-main/schematic/xschem/TG_2C.sym
** sch_path: /home/ivan_torres/UNICASS/IHP__ADC8711/ADC8711-main/schematic/xschem/TG_2C.sch
.subckt TG_2C VCTRLN VSS VOUT VIN VDD VCTRLP
*.PININFO VCTRLN:B VCTRLP:B VOUT:O VIN:I VSS:B VDD:B
MM1 VOUT VCTRLN VIN VSS sg13_lv_nmos w=0.15u l=0.13u ng=1
MM2 VOUT VCTRLP VIN VDD sg13_lv_pmos w=0.15u l=0.13u ng=1 m=2
.ends

* expanding   symbol:  INV_D3.sym # of pins=4
** sym_path: /home/ivan_torres/UNICASS/IHP__ADC8711/ADC8711-main/schematic/xschem/INV_D3.sym
** sch_path: /home/ivan_torres/UNICASS/IHP__ADC8711/ADC8711-main/schematic/xschem/INV_D3.sch
.subckt INV_D3 VDD VOUT VIN VSS
*.PININFO VDD:B VSS:B VOUT:O VIN:I
MM1 VOUT VIN VSS VSS sg13_lv_nmos w=0.15u l=0.13u ng=1 m=3
MM2 VOUT VIN VDD VDD sg13_lv_pmos w=0.15u l=0.13u ng=1 m=6
.ends
